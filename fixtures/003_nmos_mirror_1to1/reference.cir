* 1:1 NMOS current mirror. Iref into drain of M1 (diode-connected ref); Iout from drain of M2 (mirror).
M1 iref iref 0 0 NMOS W=10u L=1u
M2 iout iref 0 0 NMOS W=10u L=1u
.MODEL NMOS NMOS (LEVEL=1 VTO=1 KP=1.0e-4 LAMBDA=0.02)
.END
