* Non-inverting amplifier: NMOS-input 5T OTA with resistor-divider feedback.
* Closed-loop gain ~ 1 + Rf/Rg, set by the divider from vout to vfb to ground.
M1 voutn vinp  ntail 0   NMOS W=10u L=1u
M2 vout  vfb   ntail 0   NMOS W=10u L=1u
M3 voutn voutn vdd   vdd PMOS W=20u L=1u
M4 vout  voutn vdd   vdd PMOS W=20u L=1u
M5 ntail vbias 0     0   NMOS W=20u L=1u
Rf vout  vfb   90k
Rg vfb   0     10k
.MODEL NMOS NMOS (LEVEL=1 VTO=1 KP=1.0e-4 LAMBDA=0.02)
.MODEL PMOS PMOS (LEVEL=1 VTO=-1 KP=1.0e-4 LAMBDA=0.02)
.END
