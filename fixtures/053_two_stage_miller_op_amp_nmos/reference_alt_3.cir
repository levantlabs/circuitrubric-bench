* Two-stage Miller op-amp, NMOS input. Both refinements: nulling resistor Rc + internal Vbias generator.
M1 va vinp ntail 0 NMOS W=10u L=1u
M2 vb vinn ntail 0 NMOS W=10u L=1u
M3 va va vdd vdd PMOS W=20u L=1u
M4 vb va vdd vdd PMOS W=20u L=1u
M5 ntail vbias 0 0 NMOS W=20u L=1u
M6 vout vb vdd vdd PMOS W=40u L=1u
M7 vout vbias 0 0 NMOS W=20u L=1u
Cc vb n_zero 1p
Rc n_zero vout 1k
M8 vbias vbias 0 0 NMOS W=10u L=1u
R_bias vdd vbias 100k
.MODEL NMOS NMOS (LEVEL=1 VTO=1 KP=1.0e-4 LAMBDA=0.02)
.MODEL PMOS PMOS (LEVEL=1 VTO=-1 KP=1.0e-4 LAMBDA=0.02)
.END
