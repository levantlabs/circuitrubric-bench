* Wilson PMOS current mirror, 4-T improved form (1:1).
* M4 (diode-connected at iref) balances V_DS between the matched mirror pair
* (M1, M3) to reduce channel-length modulation mismatch.
M1 n_xref n1 vdd vdd PMOS W=20u L=1u
M2 iout iref n1 vdd PMOS W=20u L=1u
M3 n1 n1 vdd vdd PMOS W=20u L=1u
M4 iref iref n_xref vdd PMOS W=20u L=1u
.MODEL PMOS PMOS (LEVEL=1 VTO=-1 KP=1.0e-4 LAMBDA=0.02)
.END
