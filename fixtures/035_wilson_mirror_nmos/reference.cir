* Wilson NMOS current mirror, 3-transistor form (1:1).
* M3 diode-connected at n1 sets V_GS from output current; M1 mirrors that V_GS
* on the reference leg. M2 is the output cascode whose gate=iref provides the
* feedback that boosts output impedance.
M1 iref n1 0 0 NMOS W=10u L=1u
M2 iout iref n1 0 NMOS W=10u L=1u
M3 n1 n1 0 0 NMOS W=10u L=1u
.MODEL NMOS NMOS (LEVEL=1 VTO=1 KP=1.0e-4 LAMBDA=0.02)
.END
