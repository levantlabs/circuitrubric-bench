* Wilson NMOS current mirror, 4-transistor improved form (1:1).
* Adds M4 (diode-connected at iref) above M1 on the reference leg, balancing
* V_DS,M1 with V_DS,M3 to reduce channel-length modulation mismatch between
* the matched mirror pair.
M1 n_xref n1 0 0 NMOS W=10u L=1u
M2 iout iref n1 0 NMOS W=10u L=1u
M3 n1 n1 0 0 NMOS W=10u L=1u
M4 iref iref n_xref 0 NMOS W=10u L=1u
.MODEL NMOS NMOS (LEVEL=1 VTO=1 KP=1.0e-4 LAMBDA=0.02)
.END
