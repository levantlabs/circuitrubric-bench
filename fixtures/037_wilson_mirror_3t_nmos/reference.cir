* Wilson NMOS current mirror, 3-transistor form (1:1).
* Only the 3-T form is accepted for this fixture; 4-T improved Wilson is graded
* separately as 039.
M1 iref n1 0 0 NMOS W=10u L=1u
M2 iout iref n1 0 NMOS W=10u L=1u
M3 n1 n1 0 0 NMOS W=10u L=1u
.MODEL NMOS NMOS (LEVEL=1 VTO=1 KP=1.0e-4 LAMBDA=0.02)
.END
