* NMOS source follower with NMOS current-source load.
M1 vdd vin vout 0 NMOS W=20u L=1u
M2 vout vbias 0 0 NMOS W=20u L=1u
.MODEL NMOS NMOS (LEVEL=1 VTO=1 KP=1.0e-4 LAMBDA=0.02)
.END
