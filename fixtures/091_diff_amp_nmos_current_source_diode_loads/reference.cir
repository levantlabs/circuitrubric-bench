* NMOS differential amplifier with parallel current-source + diode-connected loads.
* Per output side: a PMOS current source (M3/M4) and a PMOS diode (M5/M6) in parallel.
M1 voutn vinp  ntail 0   NMOS W=20u L=1u
M2 voutp vinn  ntail 0   NMOS W=20u L=1u
M3 voutn vbp   vdd   vdd PMOS W=40u L=1u
M4 voutp vbp   vdd   vdd PMOS W=40u L=1u
M5 voutn voutn vdd   vdd PMOS W=20u L=1u
M6 voutp voutp vdd   vdd PMOS W=20u L=1u
M7 ntail vbias 0     0   NMOS W=40u L=1u
.MODEL NMOS NMOS (LEVEL=1 VTO=1 KP=1.0e-4 LAMBDA=0.02)
.MODEL PMOS PMOS (LEVEL=1 VTO=-1 KP=1.0e-4 LAMBDA=0.02)
.END
