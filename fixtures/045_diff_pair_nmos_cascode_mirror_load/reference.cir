* NMOS-input diff pair with cascode PMOS mirror load (7T cascoded 5T OTA).
M1 voutn vinp ntail 0 NMOS W=10u L=1u
M2 voutp vinn ntail 0 NMOS W=10u L=1u
M3 n1 n1 vdd vdd PMOS W=20u L=1u
M4 voutn voutn n1 vdd PMOS W=20u L=1u
M5 n2 n1 vdd vdd PMOS W=20u L=1u
M6 voutp voutn n2 vdd PMOS W=20u L=1u
M7 ntail vbias 0 0 NMOS W=20u L=1u
.MODEL NMOS NMOS (LEVEL=1 VTO=1 KP=1.0e-4 LAMBDA=0.02)
.MODEL PMOS PMOS (LEVEL=1 VTO=-1 KP=1.0e-4 LAMBDA=0.02)
.END
