* NMOS common-source amplifier with PMOS diode-connected load.
* M1 is the input device, M2 is the diode-connected PMOS load (gate=drain at vout).
M1 vout vin   0   0   NMOS W=10u L=1u
M2 vout vout vdd vdd PMOS W=20u L=1u
.MODEL NMOS NMOS (LEVEL=1 VTO=1 KP=1.0e-4 LAMBDA=0.02)
.MODEL PMOS PMOS (LEVEL=1 VTO=-1 KP=1.0e-4 LAMBDA=0.02)
.END
