* Two-stage single-ended NMOS amplifier: cascaded common-source stages with resistor loads.
M1 n1 vin 0 0 NMOS W=10u L=1u
R1 vdd n1 10k
M2 vout n1 0 0 NMOS W=10u L=1u
R2 vdd vout 10k
.MODEL NMOS NMOS (LEVEL=1 VTO=1 KP=1.0e-4 LAMBDA=0.02)
.END
