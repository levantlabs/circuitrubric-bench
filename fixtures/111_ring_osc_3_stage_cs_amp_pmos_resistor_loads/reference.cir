* 3-stage CS-amp ring oscillator with resistor loads (PMOS).
* Three PMOS CS stages in a loop: vout -> v1 -> v2 -> vout.
M1 v1   vout vdd vdd PMOS W=20u L=1u
R1 v1   0    10k
M2 v2   v1   vdd vdd PMOS W=20u L=1u
R2 v2   0    10k
M3 vout v2   vdd vdd PMOS W=20u L=1u
R3 vout 0    10k
.MODEL NMOS NMOS (LEVEL=1 VTO=1 KP=1.0e-4 LAMBDA=0.02)
.MODEL PMOS PMOS (LEVEL=1 VTO=-1 KP=1.0e-4 LAMBDA=0.02)
.END
