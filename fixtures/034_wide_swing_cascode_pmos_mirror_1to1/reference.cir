* Wide-swing cascode PMOS mirror, 5-T Sooch form.
* All devices same W/L=20u/1u. M5 (bias-gen, diode-connected) is M=1; M1-M4 are
* M=4 each. The 4x relative scaling sets |V_GS,M5| ~2*V_DSsat above the others,
* biasing vbias to keep M2/M4 at edge of saturation.
M5 vbias vbias vdd vdd PMOS W=20u L=1u
M1 iref vbias n1 vdd PMOS W=20u L=1u M=4
M2 n1 iref vdd vdd PMOS W=20u L=1u M=4
M3 iout vbias n2 vdd PMOS W=20u L=1u M=4
M4 n2 iref vdd vdd PMOS W=20u L=1u M=4
.MODEL PMOS PMOS (LEVEL=1 VTO=-1 KP=1.0e-4 LAMBDA=0.02)
.END
