* Wide-swing cascode PMOS mirror, 4-T external-bias form (vbias supplied externally).
M1 iref vbias n1 vdd PMOS W=20u L=1u
M2 n1 iref vdd vdd PMOS W=20u L=1u
M3 iout vbias n2 vdd PMOS W=20u L=1u
M4 n2 iref vdd vdd PMOS W=20u L=1u
.MODEL PMOS PMOS (LEVEL=1 VTO=-1 KP=1.0e-4 LAMBDA=0.02)
.END
