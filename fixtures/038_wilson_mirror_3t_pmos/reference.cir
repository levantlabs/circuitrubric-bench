* Wilson PMOS current mirror, 3-transistor form (1:1).
* Only the 3-T form is accepted for this fixture; 4-T improved Wilson is graded
* separately as 040.
M1 iref n1 vdd vdd PMOS W=20u L=1u
M2 iout iref n1 vdd PMOS W=20u L=1u
M3 n1 n1 vdd vdd PMOS W=20u L=1u
.MODEL PMOS PMOS (LEVEL=1 VTO=-1 KP=1.0e-4 LAMBDA=0.02)
.END
