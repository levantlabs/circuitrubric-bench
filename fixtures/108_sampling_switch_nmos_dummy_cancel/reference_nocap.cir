* NMOS sampling switch w/ dummy cancel — switch only, hold cap treated as
* external load (the `short` prompt names no capacitor, so a switch-only answer
* that follows the no-load-cap convention is equally valid). Accepts both.
M1 vout clk  vin  0 NMOS W=10u L=1u
M2 vout clkb vout 0 NMOS W=5u  L=1u
.MODEL NMOS NMOS (LEVEL=1 VTO=1 KP=1.0e-4 LAMBDA=0.02)
.END
