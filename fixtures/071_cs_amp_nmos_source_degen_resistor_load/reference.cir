* NMOS common-source amplifier with source degeneration and resistor load.
* Rs (between source and ground) sets the degeneration; Rd (between drain and VDD)
* is the drain load. M1 sees body effect since source != bulk.
M1 vout vin vs 0 NMOS W=10u L=1u
Rs vs   0   1k
Rd vdd  vout 10k
.MODEL NMOS NMOS (LEVEL=1 VTO=1 KP=1.0e-4 LAMBDA=0.02)
.END
