* PMOS sampling switch, alt: drain/source swapped (pass transistor is symmetric).
M1 vin clk vout vdd PMOS W=20u L=1u
Ch vout 0   1p
.MODEL NMOS NMOS (LEVEL=1 VTO=1 KP=1.0e-4 LAMBDA=0.02)
.MODEL PMOS PMOS (LEVEL=1 VTO=-1 KP=1.0e-4 LAMBDA=0.02)
.END
