* CMOS transmission gate (crossed: NMOS drain at vout, PMOS drain at vin).
* The pass transistor is physically symmetric; SPICE forces a drain/source
* labeling choice. This variant covers the case where the model picks
* opposite drain/source assignments for the two devices.
M1 vout en  vin 0    NMOS W=10u L=1u
M2 vin  enb vout vdd PMOS W=20u L=1u
.MODEL NMOS NMOS (LEVEL=1 VTO=1 KP=1.0e-4 LAMBDA=0.02)
.MODEL PMOS PMOS (LEVEL=1 VTO=-1 KP=1.0e-4 LAMBDA=0.02)
.END
