* NMOS diff pair, source degeneration via R from each source to a shared ntail, with one tail source.
M1 voutn vinp ns1 0 NMOS W=20u L=1u
M2 voutp vinn ns2 0 NMOS W=20u L=1u
R1 vdd voutn 10k
R2 vdd voutp 10k
R3 ns1 ntail 500
R4 ns2 ntail 500
M3 ntail vbias 0 0 NMOS W=40u L=1u
.MODEL NMOS NMOS (LEVEL=1 VTO=1 KP=1.0e-4 LAMBDA=0.02)
.END
