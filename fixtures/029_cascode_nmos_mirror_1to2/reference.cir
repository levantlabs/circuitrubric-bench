* Cascode NMOS current mirror, 1 to 2. M1/M2 reference stack (1 device each); M3/M4 output stack (M=2 each).
M1 n1 n1 0 0 NMOS W=10u L=1u
M2 iref iref n1 0 NMOS W=10u L=1u
M3 n2 n1 0 0 NMOS W=10u L=1u M=2
M4 iout iref n2 0 NMOS W=10u L=1u M=2
.MODEL NMOS NMOS (LEVEL=1 VTO=1 KP=1.0e-4 LAMBDA=0.02)
.END
