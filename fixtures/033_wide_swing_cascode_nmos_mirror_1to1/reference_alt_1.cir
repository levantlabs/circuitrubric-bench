* Wide-swing cascode NMOS mirror, 4-T external-bias form (vbias supplied externally).
M1 iref vbias n1 0 NMOS W=10u L=1u
M2 n1 iref 0 0 NMOS W=10u L=1u
M3 iout vbias n2 0 NMOS W=10u L=1u
M4 n2 iref 0 0 NMOS W=10u L=1u
.MODEL NMOS NMOS (LEVEL=1 VTO=1 KP=1.0e-4 LAMBDA=0.02)
.END
