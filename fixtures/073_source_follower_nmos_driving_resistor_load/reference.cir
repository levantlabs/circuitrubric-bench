* NMOS source follower with NMOS current-source bias and a resistor output load.
* M1 is the source follower; M2 is the NMOS current-source bias; RL is the
* external load impedance, in parallel with M2 from vout to ground.
M1 vdd  vin   vout 0 NMOS W=20u L=1u
M2 vout vbias 0    0 NMOS W=20u L=1u
RL vout 0     1k
.MODEL NMOS NMOS (LEVEL=1 VTO=1 KP=1.0e-4 LAMBDA=0.02)
.END
