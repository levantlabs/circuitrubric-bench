* PMOS-input telescopic cascode OTA, fully differential output (9T).
* All cascode/current-source gates from external bias; no diode, no mirror.
M1 p_a1  vinp  ntail vdd PMOS W=20u L=1u
M2 p_a2  vinn  ntail vdd PMOS W=20u L=1u
M3 voutn vcp   p_a1  vdd PMOS W=20u L=1u
M4 voutp vcp   p_a2  vdd PMOS W=20u L=1u
M5 voutn vcn   n_b1  0   NMOS W=10u L=1u
M6 voutp vcn   n_b2  0   NMOS W=10u L=1u
M7 n_b1  vbn   0     0   NMOS W=10u L=1u
M8 n_b2  vbn   0     0   NMOS W=10u L=1u
M9 ntail vbias vdd   vdd PMOS W=40u L=1u
.MODEL NMOS NMOS (LEVEL=1 VTO=1 KP=1.0e-4 LAMBDA=0.02)
.MODEL PMOS PMOS (LEVEL=1 VTO=-1 KP=1.0e-4 LAMBDA=0.02)
.END
