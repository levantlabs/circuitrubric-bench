* Cascode NMOS current mirror, 1 to 1, standard textbook form (4 transistors, 2 diode-connected pairs).
* M1/M2 reference stack (both diode-connected); M3/M4 output stack mirroring.
M1 n1 n1 0 0 NMOS W=10u L=1u
M2 iref iref n1 0 NMOS W=10u L=1u
M3 n2 n1 0 0 NMOS W=10u L=1u
M4 iout iref n2 0 NMOS W=10u L=1u
.MODEL NMOS NMOS (LEVEL=1 VTO=1 KP=1.0e-4 LAMBDA=0.02)
.END
