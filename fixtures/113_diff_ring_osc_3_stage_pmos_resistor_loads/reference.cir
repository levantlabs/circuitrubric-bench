* 3-stage differential ring oscillator (PMOS diff amps with resistor loads).

* Stage 1: inputs from stage 3 (voutn -> M1.gate, voutp -> M2.gate)
M1 v1n  voutn nt1 vdd PMOS W=40u L=1u
M2 v1p  voutp nt1 vdd PMOS W=40u L=1u
R1 v1n  0     10k
R2 v1p  0     10k
M3 nt1  vbias vdd vdd PMOS W=80u L=1u

* Stage 2
M4 v2n  v1n   nt2 vdd PMOS W=40u L=1u
M5 v2p  v1p   nt2 vdd PMOS W=40u L=1u
R3 v2n  0     10k
R4 v2p  0     10k
M6 nt2  vbias vdd vdd PMOS W=80u L=1u

* Stage 3 (outputs voutn/voutp close the ring)
M7 voutn v2n  nt3 vdd PMOS W=40u L=1u
M8 voutp v2p  nt3 vdd PMOS W=40u L=1u
R5 voutn 0    10k
R6 voutp 0    10k
M9 nt3  vbias vdd vdd PMOS W=80u L=1u

.MODEL NMOS NMOS (LEVEL=1 VTO=1 KP=1.0e-4 LAMBDA=0.02)
.MODEL PMOS PMOS (LEVEL=1 VTO=-1 KP=1.0e-4 LAMBDA=0.02)
.END
