* CMOS sampling switch, alt: crossed PMOS D/S (pass devices are symmetric).
M1 vout en  vin 0    NMOS W=10u L=1u
M2 vin  enb vout vdd PMOS W=20u L=1u
Ch vout 0   1p
.MODEL NMOS NMOS (LEVEL=1 VTO=1 KP=1.0e-4 LAMBDA=0.02)
.MODEL PMOS PMOS (LEVEL=1 VTO=-1 KP=1.0e-4 LAMBDA=0.02)
.END
