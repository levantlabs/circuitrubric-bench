* Cascade of an NMOS common-source stage and an NMOS source follower.
* Stage 1: M1 CS amp with resistor load R1. Stage 2: M2 source follower with
* M3 as the NMOS current-source bias.
M1 n1   vin   0    0 NMOS W=10u L=1u
R1 vdd  n1    10k
M2 vdd  n1    vout 0 NMOS W=20u L=1u
M3 vout vbias 0    0 NMOS W=20u L=1u
.MODEL NMOS NMOS (LEVEL=1 VTO=1 KP=1.0e-4 LAMBDA=0.02)
.END
