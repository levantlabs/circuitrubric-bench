* Cascoded PMOS common-source amplifier with a cascoded NMOS current-source load.
* M1 PMOS CS input, M2 PMOS cascode, M3 NMOS cascode, M4 NMOS current source.
M1 mid_p vin   vdd vdd PMOS W=40u L=1u
M2 vout  vbp   mid_p vdd PMOS W=40u L=1u
M3 vout  vbn   mid_n 0   NMOS W=20u L=1u
M4 mid_n vbn2  0     0   NMOS W=20u L=1u
.MODEL NMOS NMOS (LEVEL=1 VTO=1 KP=1.0e-4 LAMBDA=0.02)
.MODEL PMOS PMOS (LEVEL=1 VTO=-1 KP=1.0e-4 LAMBDA=0.02)
.END
