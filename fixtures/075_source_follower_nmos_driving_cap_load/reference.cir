* NMOS source follower with NMOS current-source bias and a capacitive output load.
* M1 is the source follower; M2 is the NMOS current-source bias; CL is the
* external capacitive load on the output node.
M1 vdd  vin   vout 0 NMOS W=20u L=1u
M2 vout vbias 0    0 NMOS W=20u L=1u
CL vout 0     1p
.MODEL NMOS NMOS (LEVEL=1 VTO=1 KP=1.0e-4 LAMBDA=0.02)
.END
