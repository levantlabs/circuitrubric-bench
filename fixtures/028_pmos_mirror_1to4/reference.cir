* 1 to 4 PMOS current mirror. M1 reference (1 device); M2 mirror (M=4 devices, same W).
M1 iref iref vdd vdd PMOS W=20u L=1u
M2 iout iref vdd vdd PMOS W=20u L=1u M=4
.MODEL PMOS PMOS (LEVEL=1 VTO=-1 KP=1.0e-4 LAMBDA=0.02)
.END
