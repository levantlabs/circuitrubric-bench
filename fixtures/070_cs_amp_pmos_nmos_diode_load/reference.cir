* PMOS common-source amplifier with NMOS diode-connected load.
* M1 is the PMOS input device (source at VDD); M2 is the NMOS diode load
* (gate=drain at vout, source/bulk at ground; no body effect on the load).
M1 vout vin   vdd vdd PMOS W=20u L=1u
M2 vout vout 0   0   NMOS W=10u L=1u
.MODEL NMOS NMOS (LEVEL=1 VTO=1 KP=1.0e-4 LAMBDA=0.02)
.MODEL PMOS PMOS (LEVEL=1 VTO=-1 KP=1.0e-4 LAMBDA=0.02)
.END
