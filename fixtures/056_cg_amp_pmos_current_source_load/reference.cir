* PMOS common-gate amplifier with NMOS current-source load.
* M1 is the CG device (input at source, output at drain, gate biased at vbias).
* M2 is the NMOS current-source load (gate biased at vbn).
M1 vout vbias vin vdd PMOS W=40u L=1u
M2 vout vbn 0 0 NMOS W=20u L=1u
.MODEL NMOS NMOS (LEVEL=1 VTO=1 KP=1.0e-4 LAMBDA=0.02)
.MODEL PMOS PMOS (LEVEL=1 VTO=-1 KP=1.0e-4 LAMBDA=0.02)
.END
