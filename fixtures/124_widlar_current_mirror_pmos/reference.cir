* Widlar PMOS current source.
* M1 diode-connected reference (no degeneration); M2 output device with a
* single degeneration resistor R1 between VDD and its source. Asymmetric
* degeneration produces a logarithmic Iout-vs-Iref relationship.
M1 iref iref vdd vdd PMOS W=20u L=1u
M2 iout iref ps  vdd PMOS W=20u L=1u
R1 vdd  ps   1k
.MODEL NMOS NMOS (LEVEL=1 VTO=1 KP=1.0e-4 LAMBDA=0.02)
.MODEL PMOS PMOS (LEVEL=1 VTO=-1 KP=1.0e-4 LAMBDA=0.02)
.END
