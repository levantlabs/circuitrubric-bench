* NMOS source follower with resistor load to ground.
M1 vdd vin vout 0 NMOS W=20u L=1u
R1 vout 0 10k
.MODEL NMOS NMOS (LEVEL=1 VTO=1 KP=1.0e-4 LAMBDA=0.02)
.END
