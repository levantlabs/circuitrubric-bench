* NMOS common-gate amplifier, resistor load, AC-coupled input, current-source bias.
* M1 is the CG device; RL is the drain load; Cin AC-couples the input to the
* source node vs; M2 is the NMOS current source setting the DC level at vs.
M1 vout vbias vs 0 NMOS W=10u L=1u
RL vdd  vout  10k
Cin vin vs    1u
M2 vs   vbn   0  0 NMOS W=20u L=1u
.MODEL NMOS NMOS (LEVEL=1 VTO=1 KP=1.0e-4 LAMBDA=0.02)
.END
