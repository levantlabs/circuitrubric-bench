* Unity-gain buffer based on the NMOS-input 5T OTA.
* The OTA's output is tied to its inverting input (M2's gate), making
* the inverting input = output node (called vout below).
M1 voutn vinp  ntail 0   NMOS W=10u L=1u
M2 vout  vout  ntail 0   NMOS W=10u L=1u
M3 voutn voutn vdd   vdd PMOS W=20u L=1u
M4 vout  voutn vdd   vdd PMOS W=20u L=1u
M5 ntail vbias 0     0   NMOS W=20u L=1u
.MODEL NMOS NMOS (LEVEL=1 VTO=1 KP=1.0e-4 LAMBDA=0.02)
.MODEL PMOS PMOS (LEVEL=1 VTO=-1 KP=1.0e-4 LAMBDA=0.02)
.END
