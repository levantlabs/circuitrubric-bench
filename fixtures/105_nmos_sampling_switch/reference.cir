* NMOS sampling switch with hold capacitor.
* M1 is the pass device (drain at vout, source at vin); Ch holds the sampled
* voltage at vout when M1 turns off.
M1 vout clk vin 0 NMOS W=10u L=1u
Ch vout 0   1p
.MODEL NMOS NMOS (LEVEL=1 VTO=1 KP=1.0e-4 LAMBDA=0.02)
.END
