* NMOS common-source amplifier with NMOS diode-connected load.
* M1 is the input device, M2 is the diode-connected NMOS load (gate=drain at VDD).
* M2 sees body effect (source at vout, bulk at ground).
M1 vout vin 0   0 NMOS W=10u L=1u
M2 vdd  vdd vout 0 NMOS W=20u L=1u
.MODEL NMOS NMOS (LEVEL=1 VTO=1 KP=1.0e-4 LAMBDA=0.02)
.END
