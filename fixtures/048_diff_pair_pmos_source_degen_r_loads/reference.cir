* PMOS diff pair, source degeneration via R between input pair sources, with two tail sources.
M1 voutn vinp ns1 vdd PMOS W=40u L=1u
M2 voutp vinn ns2 vdd PMOS W=40u L=1u
R1 voutn 0 10k
R2 voutp 0 10k
R3 ns1 ns2 1k
M3 ns1 vbias vdd vdd PMOS W=40u L=1u
M4 ns2 vbias vdd vdd PMOS W=40u L=1u
.MODEL PMOS PMOS (LEVEL=1 VTO=-1 KP=1.0e-4 LAMBDA=0.02)
.END
