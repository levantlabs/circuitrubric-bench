* PMOS common-source amplifier with NMOS current-source load.
M1 vout vin vdd vdd PMOS W=20u L=1u
M2 vout vbias 0 0 NMOS W=10u L=1u
.MODEL NMOS NMOS (LEVEL=1 VTO=1 KP=1.0e-4 LAMBDA=0.02)
.MODEL PMOS PMOS (LEVEL=1 VTO=-1 KP=1.0e-4 LAMBDA=0.02)
.END
