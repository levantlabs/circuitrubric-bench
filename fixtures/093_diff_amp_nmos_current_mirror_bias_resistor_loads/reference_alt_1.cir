* NMOS differential amplifier, resistor loads, tail biased by a current mirror.
* Alt: the mirror reference current is set by an ideal current source Iref
* (from VDD into the mirror node) instead of a bias resistor.
M1 voutn vinp  ntail 0 NMOS W=20u L=1u
M2 voutp vinn  ntail 0 NMOS W=20u L=1u
R1 vdd  voutn  10k
R2 vdd  voutp  10k
M3 ntail nmir  0     0 NMOS W=40u L=1u
M4 nmir  nmir  0     0 NMOS W=40u L=1u
Iref vdd nmir 10u
.MODEL NMOS NMOS (LEVEL=1 VTO=1 KP=1.0e-4 LAMBDA=0.02)
.END
