* NMOS-input telescopic cascode OTA, single-ended output (9T).
M1 n_a1 vinp ntail 0 NMOS W=10u L=1u
M2 n_a2 vinn ntail 0 NMOS W=10u L=1u
M3 voutn vcasc_n n_a1 0 NMOS W=10u L=1u
M4 voutp vcasc_n n_a2 0 NMOS W=10u L=1u
M5 voutn voutn n_b1 vdd PMOS W=20u L=1u
M6 voutp voutn n_b2 vdd PMOS W=20u L=1u
M7 n_b1 n_b1 vdd vdd PMOS W=20u L=1u
M8 n_b2 n_b1 vdd vdd PMOS W=20u L=1u
M9 ntail vbias 0 0 NMOS W=20u L=1u
.MODEL NMOS NMOS (LEVEL=1 VTO=1 KP=1.0e-4 LAMBDA=0.02)
.MODEL PMOS PMOS (LEVEL=1 VTO=-1 KP=1.0e-4 LAMBDA=0.02)
.END
