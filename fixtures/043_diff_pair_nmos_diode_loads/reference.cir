* NMOS diff pair with PMOS diode-connected loads (fully differential).
M1 voutn vinp ntail 0 NMOS W=20u L=1u
M2 voutp vinn ntail 0 NMOS W=20u L=1u
M3 voutn voutn vdd vdd PMOS W=20u L=1u
M4 voutp voutp vdd vdd PMOS W=20u L=1u
M5 ntail vbias 0 0 NMOS W=40u L=1u
.MODEL NMOS NMOS (LEVEL=1 VTO=1 KP=1.0e-4 LAMBDA=0.02)
.MODEL PMOS PMOS (LEVEL=1 VTO=-1 KP=1.0e-4 LAMBDA=0.02)
.END
